.PARAM vdd_max=0.825
.PARAM vdd_typ=0.75
.PARAM vdd_min=0.6975

.PARAM vddq_max=0.57
.PARAM vddq_typ=0.5
.PARAM vddq_min=0.47

.PARAM vss_max=0
.PARAM vss_typ=0
.PARAM vss_min=0
